* R1 load step: 562 A to 1125 A in 1000 ns
* Generated by engineering/matlab/write_netlists.m from r1_params.m. Do not edit.
* Package capacitors: 368 top, 72 land side
VVRM ref 0 DC 0.8
RVRM ref vrm 2e-05
LVRM vrm board 3e-11
* BULK: 32 x 0.00047 F, ESR 0.005 ohm, ESL 8e-10 H
RBULK board bulk1 0.00015625
LBULK bulk1 bulk2 2.5e-11
CBULK bulk2 0 0.01504
* BMLCC: 120 x 2.2e-05 F, ESR 0.003 ohm, ESL 5e-10 H
RBMLCC board bmlcc1 2.5e-05
LBMLCC bmlcc1 bmlcc2 4.16667e-12
CBMLCC bmlcc2 0 0.00264
RBGA board bga 5e-06
LBGA bga pkg 3e-12
* PTOP: 368 x 2.2e-06 F, ESR 0.008 ohm, ESL 1.2e-10 H
RPTOP pkg ptop1 2.17391e-05
LPTOP ptop1 ptop2 3.26087e-13
CPTOP ptop2 0 0.0008096
* PLAND: 72 x 4.7e-06 F, ESR 0.006 ohm, ESL 4e-11 H
RPLAND pkg pland1 8.33333e-05
LPLAND pland1 pland2 5.55556e-13
CPLAND pland2 0 0.0003384
RPKG pkg pkgl 1e-05
LPKG pkgl die 1e-12
RDIE die diec 6e-05
CDIE diec 0 4e-05
ILOAD die 0 PULSE(562.5 1125 20u 1e-06 1e-06 1m 2m)
.OPTIONS METHOD=GEAR
.TRAN 0.5n 60u 0 2n
.END
