* R1 load step: 562 A to 1125 A in 50 ns
* Generated by engineering/matlab/write_netlists.m from r1_params.m. Do not edit.
* Package capacitors: 0 top, 0 land side
VVRM ref 0 DC 0.8
RVRM ref vrm 2e-05
LVRM vrm board 3e-11
* BULK: 32 x 0.00047 F, ESR 0.005 ohm, ESL 8e-10 H
RBULK board bulk1 0.00015625
LBULK bulk1 bulk2 2.5e-11
CBULK bulk2 0 0.01504
* BMLCC: 120 x 2.2e-05 F, ESR 0.003 ohm, ESL 5e-10 H
RBMLCC board bmlcc1 2.5e-05
LBMLCC bmlcc1 bmlcc2 4.16667e-12
CBMLCC bmlcc2 0 0.00264
RBGA board bga 5e-06
LBGA bga pkg 3e-12
RPKG pkg pkgl 1e-05
LPKG pkgl die 1e-12
RDIE die diec 6e-05
CDIE diec 0 4e-05
ILOAD die 0 PULSE(562.5 1125 20u 5e-08 5e-08 1m 2m)
.OPTIONS METHOD=GEAR
.TRAN 0.5n 60u 0 2n
.END
