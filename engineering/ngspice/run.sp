* Runs every TINA netlist in ngspice; results go to out/raw
* Generated by engineering/matlab/write_netlists.m. Run from engineering: ngspice -b ngspice/run.sp
.control
set wr_singlescale
set wr_vecnames
shell mkdir -p out/raw
source tina/r1_pdn_ac.cir
run
wrdata out/raw/pdn_ac.txt vm(die)
destroy all
source tina/r1_load_step.cir
run
wrdata out/raw/load_step.txt v(die)
destroy all
source tina/variants/r1_pdn_ac_no_pkg_caps.cir
run
wrdata out/raw/pdn_ac_no_pkg_caps.txt vm(die)
destroy all
source tina/variants/r1_load_step_1000ns_no_pkg_caps.cir
run
wrdata out/raw/load_step_1000ns_no_pkg_caps.txt v(die)
destroy all
source tina/variants/r1_load_step_50ns.cir
run
wrdata out/raw/load_step_50ns.txt v(die)
destroy all
source tina/variants/r1_load_step_50ns_no_pkg_caps.cir
run
wrdata out/raw/load_step_50ns_no_pkg_caps.txt v(die)
destroy all
source tina/variants/r1_load_step_10ns.cir
run
wrdata out/raw/load_step_10ns.txt v(die)
destroy all
source tina/variants/r1_load_step_10ns_no_pkg_caps.cir
run
wrdata out/raw/load_step_10ns_no_pkg_caps.txt v(die)
destroy all
.endc
.end
